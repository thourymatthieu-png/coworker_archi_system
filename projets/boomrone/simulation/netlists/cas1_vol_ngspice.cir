* Boomrone cas1 vol ? Stationnaire nominal (5,5 A, 40 m?) (force contre-?lectromotrice par moteur : 0.277 V, HYP)
Vbat vb0 0 3.7
Rint vb0 vb1 0.04
Rcon vb1 vbm 0.015
Cb1 vbm cb1 2.2e-05
Rb1 cb1 0 0.005
Cb2 vbm cb2 2.2e-05
Rb2 cb2 0 0.005
Chf vbm 0 1e-07
.model SWN SW(Vt=1.5 Vh=0.2 Ron=0.036 Roff=10Meg)
.model DSS34 D(Is=3e-06 N=1.05 Rs=0.04 Cjo=2e-10)
Vg1 g1 0 PULSE(0 3 5e-06 6.5e-08 6.5e-08 2.91667e-05 4.16667e-05)
S1 d1 0 g1 0 SWN
Rm1 vbm ma1 1
Lm1 ma1 mb1 2.5e-05
Ve1 mb1 d1 0.276644
Cm1 vbm d1 1e-07
Ds1 d1 vbm DSS34
Vg2 g2 0 PULSE(0 3 5e-06 6.5e-08 6.5e-08 2.91667e-05 4.16667e-05)
S2 d2 0 g2 0 SWN
Rm2 vbm ma2 1
Lm2 ma2 mb2 2.5e-05
Ve2 mb2 d2 0.276644
Cm2 vbm d2 1e-07
Ds2 d2 vbm DSS34
Vg3 g3 0 PULSE(0 3 5e-06 6.5e-08 6.5e-08 2.91667e-05 4.16667e-05)
S3 d3 0 g3 0 SWN
Rm3 vbm ma3 1
Lm3 ma3 mb3 2.5e-05
Ve3 mb3 d3 0.276644
Cm3 vbm d3 1e-07
Ds3 d3 vbm DSS34
Vg4 g4 0 PULSE(0 3 5e-06 6.5e-08 6.5e-08 2.91667e-05 4.16667e-05)
S4 d4 0 g4 0 SWN
Rm4 vbm ma4 1
Lm4 ma4 mb4 2.5e-05
Ve4 mb4 d4 0.276644
Cm4 vbm d4 1e-07
Ds4 d4 vbm DSS34

.tran 2e-08 0.0015 0 2e-08
.control
set filetype=ascii
run
wrdata cas1_vol_ngspice.txt v(vbm) i(vbat) i(lm1) i(lm2) i(lm3) i(lm4) v(d1)
quit
.endc
.end
